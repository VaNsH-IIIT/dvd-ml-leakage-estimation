* 8-bit parity checker, inputs 00000000, corner 0
.options gmin=1e-18 abstol=1e-18 reltol=1e-6 vntol=1e-9
.options temp=-33.99043283
.model nch nmos level = 54
+ version = 4.0   binunit = 1.0   paramchk = 1.0   mobmod = 0.0
+ capmod = 2.0   igcmod = 1.0   igbmod = 1.0   geomod = 1.0
+ diomod = 1.0   rdsmod = 0.0   rbodymod = 1.0   rgatemod = 1.0
+ permod = 1.0   acnqsmod = 0.0   trnqsmod = 0.0   tnom = 27.0
+ toxe = 9.483508113e-10   toxp = 6.5e-10   toxm = 9e-10   dtox = 2.5e-10
+ epsrox = 3.9   wint = 5e-09   lint = 2.7e-09   ll = 0.0
+ wl = 0.0   lln = 1.0   wln = 1.0   lw = 0.0
+ ww = 0.0   lwn = 1.0   wwn = 1.0   lwl = 0.0
+ wwl = 0.0   xpart = 0.0   toxref = 9e-10   xl = -2e-08
+ dlcig = 2.7e-09   vth0 = 0.3113837936   k1 = 0.2   k2 = 0.0
+ k3 = 0.0   k3b = 0.0   w0 = 2.5e-06   dvt0 = 1.0
+ dvt1 = 2.0   dvt2 = 0.0   dvt0w = 0.0   dvt1w = 0.0
+ dvt2w = 0.0   dsub = 0.078   minv = 0.05   voffl = 0.0
+ dvtp0 = 1e-10   dvtp1 = 0.1   lpe0 = 0.0   lpeb = 0.0
+ xj = 1.474583996e-08   ngate = 1e+23   ndep = 6.552644315e+18   nsd = 2e+20
+ phin = 0.0   cdsc = 0.0   cdscb = 0.0   cdscd = 0.0
+ cit = 0.0   voff = -0.13   nfactor = 1.9   eta0 = 0.0055
+ etab = 0.0   vfb = -1.058   u0 = 0.02907928272   ua = -5e-10
+ ub = 1.7e-18   uc = 0.0   vsat = 159550.0   a0 = 1.0
+ ags = 0.0   a1 = 0.0   a2 = 1.0   b0 = 0.0
+ b1 = 0.0   keta = 0.04   dwg = 0.0   dwb = 0.0
+ pclm = 0.06   pdiblc1 = 0.001   pdiblc2 = 0.001   pdiblcb = -0.005
+ drout = 0.5   pvag = 1e-20   delta = 0.01   pscbe1 = 2000000000.0
+ pscbe2 = 1e-07   fprout = 0.2   pdits = 0.01   pditsd = 0.23
+ pditsl = 2300000.0   rsh = 5.0   rdsw = 105.0   rsw = 52.5
+ rdw = 52.5   rdswmin = 0.0   rdwmin = 0.0   rswmin = 0.0
+ prwg = 0.0   prwb = 0.0   wr = 1.0   alpha0 = 0.074
+ alpha1 = 0.005   beta0 = 30.0   agidl = 0.0002   bgidl = 2100000000.0
+ cgidl = 0.0002   egidl = 0.8   aigbacc = 0.012   bigbacc = 0.0028
+ cigbacc = 0.002   nigbacc = 1.0   aigbinv = 0.014   bigbinv = 0.004
+ cigbinv = 0.004   eigbinv = 1.1   nigbinv = 3.0   aigc = 0.018029
+ bigc = 0.0029   cigc = 0.002   aigsd = 0.018029   bigsd = 0.0029
+ cigsd = 0.002   nigc = 1.0   poxedge = 1.0   pigcd = 1.0
+ ntox = 1.0   xrcrg1 = 12.0   xrcrg2 = 5.0   cgso = 1e-10
+ cgdo = 1e-10   cgbo = 0.0   cgdl = 7.5e-13   cgsl = 7.5e-13
+ clc = 1e-07   cle = 0.6   cf = 1.1e-10   ckappas = 0.6
+ ckappad = 0.6   vfbcv = -1.0   acde = 1.0   moin = 15.0
+ noff = 1.0   voffcv = 0.0   kt1 = -0.154   kt1l = 0.0
+ kt2 = 0.022   ute = -1.1   ua1 = 1e-09   ub1 = -1e-18
+ uc1 = -5.6e-11   prt = 0.0   at = 33000.0   fnoimod = 1.0
+ tnoimod = 0.0   noia = 6.25e+41   noib = 3.125e+26   noic = 8750000000.0
+ em = 41000000.0   af = 1.0   ef = 1.0   kf = 0.0
+ tnoia = 1.5   tnoib = 3.5   ntnoi = 1.0   jss = 1.2e-06
+ jsws = 2.4e-13   jswgs = 2.4e-13   njs = 1.0   ijthsfwd = 0.1
+ ijthsrev = 0.1   bvs = 10.0   xjbvs = 1.0   jsd = 1.2e-06
+ jswd = 2.4e-13   jswgd = 2.4e-13   xjbvd = 1.0   pbs = 1.0
+ cjs = 0.0018   mjs = 0.5   pbsws = 1.0   cjsws = 1.2e-10
+ mjsws = 0.33   cjswgs = 2.1e-10   cjd = 0.0018   cjswd = 1.2e-10
+ mjswd = 0.33   pbswgd = 1.0   cjswgd = 2.1e-10   mjswgd = 0.33
+ tpb = 0.0   tcj = 0.0   tpbsw = 0.0   tcjsw = 0.0
+ tpbswg = 0.0   tcjswg = 0.0   xtis = 3.0   dmcg = 0.0
+ dmci = 0.0   dmdg = 0.0   dmcgt = 0.0   dwj = 0.0
+ xgw = 0.0   xgl = 0.0   rshg = 0.4   gbmin = 1e-10
+ rbpb = 5.0   rbpd = 15.0   rbps = 15.0   rbdb = 15.0
+ rbsb = 15.0   ngcon = 1.0
.model pch pmos level = 54
+ version = 4.0   binunit = 1.0   paramchk = 1.0   mobmod = 0.0
+ capmod = 2.0   igcmod = 1.0   igbmod = 1.0   geomod = 1.0
+ diomod = 1.0   rdsmod = 0.0   rbodymod = 1.0   rgatemod = 1.0
+ permod = 1.0   acnqsmod = 0.0   trnqsmod = 0.0   tnom = 27.0
+ toxe = 9.126170967e-10   toxp = 6.5e-10   toxm = 9.2e-10   dtox = 2.7e-10
+ epsrox = 3.9   wint = 5e-09   lint = 2.7e-09   ll = 0.0
+ wl = 0.0   lln = 1.0   wln = 1.0   lw = 0.0
+ ww = 0.0   lwn = 1.0   wwn = 1.0   lwl = 0.0
+ wwl = 0.0   xpart = 0.0   toxref = 9.2e-10   xl = -2e-08
+ dlcig = 2.7e-09   vth0 = -0.2380147948   k1 = 0.2   k2 = -0.01
+ k3 = 0.0   k3b = 0.0   w0 = 2.5e-06   dvt0 = 1.0
+ dvt1 = 2.0   dvt2 = -0.032   dvt0w = 0.0   dvt1w = 0.0
+ dvt2w = 0.0   dsub = 0.1   minv = 0.05   voffl = 0.0
+ dvtp0 = 1e-11   dvtp1 = 0.05   lpe0 = 0.0   lpeb = 0.0
+ xj = 1.360756007e-08   ngate = 1e+23   ndep = 2.53210317e+18   nsd = 2e+20
+ phin = 0.0   cdsc = 0.0   cdscb = 0.0   cdscd = 0.0
+ cit = 0.0   voff = -0.13   nfactor = 1.9   eta0 = 0.0049
+ etab = 0.0   vfb = -1.058   u0 = 0.004137299808   ua = -5e-10
+ ub = 1.6e-18   uc = 0.0   vsat = 78000.0   a0 = 1.0
+ ags = 1e-20   a1 = 0.0   a2 = 1.0   b0 = 0.0
+ b1 = 0.0   keta = -0.047   dwg = 0.0   dwb = 0.0
+ pclm = 0.1   pdiblc1 = 0.001   pdiblc2 = 0.001   pdiblcb = 3.4e-08
+ drout = 0.6   pvag = 1e-20   delta = 0.01   pscbe1 = 2000000000.0
+ pscbe2 = 9.58e-07   fprout = 0.2   pdits = 0.08   pditsd = 0.23
+ pditsl = 2300000.0   rsh = 5.0   rdsw = 105.0   rsw = 52.5
+ rdw = 52.5   rdswmin = 0.0   rdwmin = 0.0   rswmin = 0.0
+ prwg = 0.0   prwb = 0.0   wr = 1.0   alpha0 = 0.074
+ alpha1 = 0.005   beta0 = 30.0   agidl = 0.0002   bgidl = 2100000000.0
+ cgidl = 0.0002   egidl = 0.8   aigbacc = 0.012   bigbacc = 0.0028
+ cigbacc = 0.002   nigbacc = 1.0   aigbinv = 0.014   bigbinv = 0.004
+ cigbinv = 0.004   eigbinv = 1.1   nigbinv = 3.0   aigc = 0.010687
+ bigc = 0.0012607   cigc = 0.0008   aigsd = 0.010687   bigsd = 0.0012607
+ cigsd = 0.0008   nigc = 1.0   poxedge = 1.0   pigcd = 1.0
+ ntox = 1.0   xrcrg1 = 12.0   xrcrg2 = 5.0   cgso = 1e-10
+ cgdo = 1e-10   cgbo = 0.0   cgdl = 3e-11   cgsl = 3e-11
+ clc = 1e-07   cle = 0.6   cf = 1.1e-10   ckappas = 0.6
+ ckappad = 0.6   vfbcv = -1.0   acde = 1.0   moin = 15.0
+ noff = 1.0   voffcv = 0.0   kt1 = -0.14   kt1l = 0.0
+ kt2 = 0.022   ute = -1.1   ua1 = 1e-09   ub1 = -1e-18
+ uc1 = -5.6e-11   prt = 0.0   at = 33000.0   fnoimod = 1.0
+ tnoimod = 0.0   noia = 6.25e+41   noib = 3.125e+26   noic = 8750000000.0
+ em = 41000000.0   af = 1.0   ef = 1.0   kf = 0.0
+ tnoia = 1.5   tnoib = 3.5   ntnoi = 1.0   jss = 2e-07
+ jsws = 4e-13   jswgs = 4e-13   njs = 1.0   ijthsfwd = 0.1
+ ijthsrev = 0.1   bvs = 10.0   xjbvs = 1.0   jsd = 2e-07
+ jswd = 4e-13   jswgd = 4e-13   xjbvd = 1.0   pbs = 1.0
+ cjs = 0.0015   mjs = 0.5   pbsws = 1.0   cjsws = 9.4e-11
+ mjsws = 0.33   cjswgs = 2e-10   cjd = 0.0015   cjswd = 9.4e-11
+ mjswd = 0.33   pbswgd = 1.0   cjswgd = 2e-10   mjswgd = 0.33
+ tpb = 0.0   tcj = 0.0   tpbsw = 0.0   tcjsw = 0.0
+ tpbswg = 0.0   tcjswg = 0.0   xtis = 3.0   dmcg = 0.0
+ dmdg = 0.0   dmcgt = 0.0   xgw = 0.0   xgl = 0.0
+ rshg = 0.1   gbmin = 1e-12   rbpb = 50.0   rbpd = 50.0
+ rbps = 50.0   rbdb = 50.0   rbsb = 50.0   ngcon = 1.0

MX0_N1_PA X0_n1 i0 vdd vdd pch W=1.24154686e-07 L=4.5e-08
MX0_N1_PB X0_n1 i1 vdd vdd pch W=1.24154686e-07 L=4.5e-08
MX0_N1_NA X0_n1 i0 X0_N1_x 0 nch W=2.053600753e-07 L=4.5e-08
MX0_N1_NB X0_N1_x i1 0 0 nch W=2.053600753e-07 L=4.5e-08
MX0_N2_PA X0_n2 i0 vdd vdd pch W=1.24154686e-07 L=4.5e-08
MX0_N2_PB X0_n2 X0_n1 vdd vdd pch W=1.24154686e-07 L=4.5e-08
MX0_N2_NA X0_n2 i0 X0_N2_x 0 nch W=2.053600753e-07 L=4.5e-08
MX0_N2_NB X0_N2_x X0_n1 0 0 nch W=2.053600753e-07 L=4.5e-08
MX0_N3_PA X0_n3 i1 vdd vdd pch W=1.24154686e-07 L=4.5e-08
MX0_N3_PB X0_n3 X0_n1 vdd vdd pch W=1.24154686e-07 L=4.5e-08
MX0_N3_NA X0_n3 i1 X0_N3_x 0 nch W=2.053600753e-07 L=4.5e-08
MX0_N3_NB X0_N3_x X0_n1 0 0 nch W=2.053600753e-07 L=4.5e-08
MX0_N4_PA x0_0 X0_n2 vdd vdd pch W=1.24154686e-07 L=4.5e-08
MX0_N4_PB x0_0 X0_n3 vdd vdd pch W=1.24154686e-07 L=4.5e-08
MX0_N4_NA x0_0 X0_n2 X0_N4_x 0 nch W=2.053600753e-07 L=4.5e-08
MX0_N4_NB X0_N4_x X0_n3 0 0 nch W=2.053600753e-07 L=4.5e-08
MX1_N1_PA X1_n1 i2 vdd vdd pch W=1.24154686e-07 L=4.5e-08
MX1_N1_PB X1_n1 i3 vdd vdd pch W=1.24154686e-07 L=4.5e-08
MX1_N1_NA X1_n1 i2 X1_N1_x 0 nch W=2.053600753e-07 L=4.5e-08
MX1_N1_NB X1_N1_x i3 0 0 nch W=2.053600753e-07 L=4.5e-08
MX1_N2_PA X1_n2 i2 vdd vdd pch W=1.24154686e-07 L=4.5e-08
MX1_N2_PB X1_n2 X1_n1 vdd vdd pch W=1.24154686e-07 L=4.5e-08
MX1_N2_NA X1_n2 i2 X1_N2_x 0 nch W=2.053600753e-07 L=4.5e-08
MX1_N2_NB X1_N2_x X1_n1 0 0 nch W=2.053600753e-07 L=4.5e-08
MX1_N3_PA X1_n3 i3 vdd vdd pch W=1.24154686e-07 L=4.5e-08
MX1_N3_PB X1_n3 X1_n1 vdd vdd pch W=1.24154686e-07 L=4.5e-08
MX1_N3_NA X1_n3 i3 X1_N3_x 0 nch W=2.053600753e-07 L=4.5e-08
MX1_N3_NB X1_N3_x X1_n1 0 0 nch W=2.053600753e-07 L=4.5e-08
MX1_N4_PA x0_1 X1_n2 vdd vdd pch W=1.24154686e-07 L=4.5e-08
MX1_N4_PB x0_1 X1_n3 vdd vdd pch W=1.24154686e-07 L=4.5e-08
MX1_N4_NA x0_1 X1_n2 X1_N4_x 0 nch W=2.053600753e-07 L=4.5e-08
MX1_N4_NB X1_N4_x X1_n3 0 0 nch W=2.053600753e-07 L=4.5e-08
MX2_N1_PA X2_n1 i4 vdd vdd pch W=1.24154686e-07 L=4.5e-08
MX2_N1_PB X2_n1 i5 vdd vdd pch W=1.24154686e-07 L=4.5e-08
MX2_N1_NA X2_n1 i4 X2_N1_x 0 nch W=2.053600753e-07 L=4.5e-08
MX2_N1_NB X2_N1_x i5 0 0 nch W=2.053600753e-07 L=4.5e-08
MX2_N2_PA X2_n2 i4 vdd vdd pch W=1.24154686e-07 L=4.5e-08
MX2_N2_PB X2_n2 X2_n1 vdd vdd pch W=1.24154686e-07 L=4.5e-08
MX2_N2_NA X2_n2 i4 X2_N2_x 0 nch W=2.053600753e-07 L=4.5e-08
MX2_N2_NB X2_N2_x X2_n1 0 0 nch W=2.053600753e-07 L=4.5e-08
MX2_N3_PA X2_n3 i5 vdd vdd pch W=1.24154686e-07 L=4.5e-08
MX2_N3_PB X2_n3 X2_n1 vdd vdd pch W=1.24154686e-07 L=4.5e-08
MX2_N3_NA X2_n3 i5 X2_N3_x 0 nch W=2.053600753e-07 L=4.5e-08
MX2_N3_NB X2_N3_x X2_n1 0 0 nch W=2.053600753e-07 L=4.5e-08
MX2_N4_PA x0_2 X2_n2 vdd vdd pch W=1.24154686e-07 L=4.5e-08
MX2_N4_PB x0_2 X2_n3 vdd vdd pch W=1.24154686e-07 L=4.5e-08
MX2_N4_NA x0_2 X2_n2 X2_N4_x 0 nch W=2.053600753e-07 L=4.5e-08
MX2_N4_NB X2_N4_x X2_n3 0 0 nch W=2.053600753e-07 L=4.5e-08
MX3_N1_PA X3_n1 i6 vdd vdd pch W=1.24154686e-07 L=4.5e-08
MX3_N1_PB X3_n1 i7 vdd vdd pch W=1.24154686e-07 L=4.5e-08
MX3_N1_NA X3_n1 i6 X3_N1_x 0 nch W=2.053600753e-07 L=4.5e-08
MX3_N1_NB X3_N1_x i7 0 0 nch W=2.053600753e-07 L=4.5e-08
MX3_N2_PA X3_n2 i6 vdd vdd pch W=1.24154686e-07 L=4.5e-08
MX3_N2_PB X3_n2 X3_n1 vdd vdd pch W=1.24154686e-07 L=4.5e-08
MX3_N2_NA X3_n2 i6 X3_N2_x 0 nch W=2.053600753e-07 L=4.5e-08
MX3_N2_NB X3_N2_x X3_n1 0 0 nch W=2.053600753e-07 L=4.5e-08
MX3_N3_PA X3_n3 i7 vdd vdd pch W=1.24154686e-07 L=4.5e-08
MX3_N3_PB X3_n3 X3_n1 vdd vdd pch W=1.24154686e-07 L=4.5e-08
MX3_N3_NA X3_n3 i7 X3_N3_x 0 nch W=2.053600753e-07 L=4.5e-08
MX3_N3_NB X3_N3_x X3_n1 0 0 nch W=2.053600753e-07 L=4.5e-08
MX3_N4_PA x0_3 X3_n2 vdd vdd pch W=1.24154686e-07 L=4.5e-08
MX3_N4_PB x0_3 X3_n3 vdd vdd pch W=1.24154686e-07 L=4.5e-08
MX3_N4_NA x0_3 X3_n2 X3_N4_x 0 nch W=2.053600753e-07 L=4.5e-08
MX3_N4_NB X3_N4_x X3_n3 0 0 nch W=2.053600753e-07 L=4.5e-08
MX4_N1_PA X4_n1 x0_0 vdd vdd pch W=1.24154686e-07 L=4.5e-08
MX4_N1_PB X4_n1 x0_1 vdd vdd pch W=1.24154686e-07 L=4.5e-08
MX4_N1_NA X4_n1 x0_0 X4_N1_x 0 nch W=2.053600753e-07 L=4.5e-08
MX4_N1_NB X4_N1_x x0_1 0 0 nch W=2.053600753e-07 L=4.5e-08
MX4_N2_PA X4_n2 x0_0 vdd vdd pch W=1.24154686e-07 L=4.5e-08
MX4_N2_PB X4_n2 X4_n1 vdd vdd pch W=1.24154686e-07 L=4.5e-08
MX4_N2_NA X4_n2 x0_0 X4_N2_x 0 nch W=2.053600753e-07 L=4.5e-08
MX4_N2_NB X4_N2_x X4_n1 0 0 nch W=2.053600753e-07 L=4.5e-08
MX4_N3_PA X4_n3 x0_1 vdd vdd pch W=1.24154686e-07 L=4.5e-08
MX4_N3_PB X4_n3 X4_n1 vdd vdd pch W=1.24154686e-07 L=4.5e-08
MX4_N3_NA X4_n3 x0_1 X4_N3_x 0 nch W=2.053600753e-07 L=4.5e-08
MX4_N3_NB X4_N3_x X4_n1 0 0 nch W=2.053600753e-07 L=4.5e-08
MX4_N4_PA x1_0 X4_n2 vdd vdd pch W=1.24154686e-07 L=4.5e-08
MX4_N4_PB x1_0 X4_n3 vdd vdd pch W=1.24154686e-07 L=4.5e-08
MX4_N4_NA x1_0 X4_n2 X4_N4_x 0 nch W=2.053600753e-07 L=4.5e-08
MX4_N4_NB X4_N4_x X4_n3 0 0 nch W=2.053600753e-07 L=4.5e-08
MX5_N1_PA X5_n1 x0_2 vdd vdd pch W=1.24154686e-07 L=4.5e-08
MX5_N1_PB X5_n1 x0_3 vdd vdd pch W=1.24154686e-07 L=4.5e-08
MX5_N1_NA X5_n1 x0_2 X5_N1_x 0 nch W=2.053600753e-07 L=4.5e-08
MX5_N1_NB X5_N1_x x0_3 0 0 nch W=2.053600753e-07 L=4.5e-08
MX5_N2_PA X5_n2 x0_2 vdd vdd pch W=1.24154686e-07 L=4.5e-08
MX5_N2_PB X5_n2 X5_n1 vdd vdd pch W=1.24154686e-07 L=4.5e-08
MX5_N2_NA X5_n2 x0_2 X5_N2_x 0 nch W=2.053600753e-07 L=4.5e-08
MX5_N2_NB X5_N2_x X5_n1 0 0 nch W=2.053600753e-07 L=4.5e-08
MX5_N3_PA X5_n3 x0_3 vdd vdd pch W=1.24154686e-07 L=4.5e-08
MX5_N3_PB X5_n3 X5_n1 vdd vdd pch W=1.24154686e-07 L=4.5e-08
MX5_N3_NA X5_n3 x0_3 X5_N3_x 0 nch W=2.053600753e-07 L=4.5e-08
MX5_N3_NB X5_N3_x X5_n1 0 0 nch W=2.053600753e-07 L=4.5e-08
MX5_N4_PA x1_1 X5_n2 vdd vdd pch W=1.24154686e-07 L=4.5e-08
MX5_N4_PB x1_1 X5_n3 vdd vdd pch W=1.24154686e-07 L=4.5e-08
MX5_N4_NA x1_1 X5_n2 X5_N4_x 0 nch W=2.053600753e-07 L=4.5e-08
MX5_N4_NB X5_N4_x X5_n3 0 0 nch W=2.053600753e-07 L=4.5e-08
MX6_N1_PA X6_n1 x1_0 vdd vdd pch W=1.24154686e-07 L=4.5e-08
MX6_N1_PB X6_n1 x1_1 vdd vdd pch W=1.24154686e-07 L=4.5e-08
MX6_N1_NA X6_n1 x1_0 X6_N1_x 0 nch W=2.053600753e-07 L=4.5e-08
MX6_N1_NB X6_N1_x x1_1 0 0 nch W=2.053600753e-07 L=4.5e-08
MX6_N2_PA X6_n2 x1_0 vdd vdd pch W=1.24154686e-07 L=4.5e-08
MX6_N2_PB X6_n2 X6_n1 vdd vdd pch W=1.24154686e-07 L=4.5e-08
MX6_N2_NA X6_n2 x1_0 X6_N2_x 0 nch W=2.053600753e-07 L=4.5e-08
MX6_N2_NB X6_N2_x X6_n1 0 0 nch W=2.053600753e-07 L=4.5e-08
MX6_N3_PA X6_n3 x1_1 vdd vdd pch W=1.24154686e-07 L=4.5e-08
MX6_N3_PB X6_n3 X6_n1 vdd vdd pch W=1.24154686e-07 L=4.5e-08
MX6_N3_NA X6_n3 x1_1 X6_N3_x 0 nch W=2.053600753e-07 L=4.5e-08
MX6_N3_NB X6_N3_x X6_n1 0 0 nch W=2.053600753e-07 L=4.5e-08
MX6_N4_PA p X6_n2 vdd vdd pch W=1.24154686e-07 L=4.5e-08
MX6_N4_PB p X6_n3 vdd vdd pch W=1.24154686e-07 L=4.5e-08
MX6_N4_NA p X6_n2 X6_N4_x 0 nch W=2.053600753e-07 L=4.5e-08
MX6_N4_NB X6_N4_x X6_n3 0 0 nch W=2.053600753e-07 L=4.5e-08
Vdd vdd 0 0.9351001054
Vi0 i0 0 0.0
Vi1 i1 0 0.0
Vi2 i2 0 0.0
Vi3 i3 0 0.0
Vi4 i4 0 0.0
Vi5 i5 0 0.0
Vi6 i6 0 0.0
Vi7 i7 0 0.0
.control
set numdgt=12
op
print i(vdd) i(vi0) i(vi1) i(vi2) i(vi3) i(vi4) i(vi5) i(vi6) i(vi7) v(p)
.endc
.end
